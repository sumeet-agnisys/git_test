//Agnisys, Inc. ***** Copyright 2018 All Rights Reserved. *****
//
//*** This file is auto generated by IDesignSpec (http://www.agnisys.com) . Please do not edit this file. ***
// created by        : 
// generated by      : Admin
// generated from    : C:\Users\Admin\Documents\GitHub\git_test\Allegro_test\case1\case1.idsng
// IDesignSpec rev   : idsbatch v4.16.26.2

//*** This code is generated with following settings ***
// Reg Width                  : 32
// Address Unit               : 8
// C++ Types int              : hwint
// Bus Type                   : AXI
// BigEndian                  : false
// LittleEndian               : false
// Dist. Decode and Readback  : false
//---------------------------------------------------------------------------------------------------------------       
         property hdl_path { type = string; component = addrmap|regfile|reg|field; };
           
         property coverage { type = string; component = addrmap | regfile | reg; };
     
         property doc { type = string; component = addrmap|regfile|reg|field; };
         
// chip : chip_name

addrmap chip_name {
  name = "chip_name Address Map";
    coverage = "on";

  addrmap block1 {
    name = "block1 Address Map";
    hdl_path = "block1_idsinst";
    coverage = "on";

      
      
    reg reg1 { 
       hdl_path = "reg1";
       coverage = "on";
       regwidth = 32;
      field {
        hdl_path = "_fld_q";
        hw = rw;
        sw = rw;
        

      } fld[31:0] = 32'h0;

    };
 
      
    addrmap reggroup1 {
      name = "reggroup1 Address Map";
      coverage = "on";

         
         
      reg reg1 { 
         hdl_path = "reggroup1_reg1";
         coverage = "on";
         regwidth = 32;
        field {
          hdl_path = "_fld_q";
          hw = rw;
          sw = rw;
          

        } fld[31:0] = 32'h0;

      };
 
         
      reg reg2 { 
         hdl_path = "reggroup1_reg2";
         coverage = "on";
         regwidth = 32;
        field {
          hdl_path = "_fld1_q";
          hw = rw;
          sw = rw;
          

        } fld1[31:0] = 32'h0;

      };
 
      
      reg1 reg1 @0x00;

      reg2 reg2 @0x04;

    };
   
    reg1 reg1 @0x00;

    reggroup1  reggroup1 @0x04 += 0x8;

  };
  addrmap block2 {
    name = "block2 Address Map";
    hdl_path = "block2_idsinst";
    coverage = "on";

      
      
    addrmap reggroup1 {
      name = "reggroup1 Address Map";
      coverage = "on";

         
         
      reg reg1 { 
         hdl_path = "reggroup1_reg1";
         coverage = "on";
         regwidth = 32;
        field {
          hdl_path = "_fld_q";
          hw = rw;
          sw = rw;
          

        } fld[31:0] = 32'h0;

      };
 
         
      reg reg2 { 
         hdl_path = "reggroup1_reg2";
         coverage = "on";
         regwidth = 32;
        field {
          hdl_path = "_fld1_q";
          hw = rw;
          sw = rw;
          

        } fld1[31:0] = 32'h0;

      };
 
      
      reg1 reg1 @0x00;

      reg2 reg2 @0x04;

    };
      
    addrmap ref_name {
      name = "ref_name Address Map";
      coverage = "on";
      map_type = "subblock";

         
         
         
      reg reg1 { 
         hdl_path = "ref_name_reg1";
         coverage = "on";
         regwidth = 32;
        field {
          hdl_path = "_fld_q";
          hw = rw;
          sw = rw;
          

        } fld[31:0] = 32'h0;

      };
 
         
      addrmap ref_name_ref_name_reggroup1 {
        name = "ref_name_ref_name_reggroup1 Address Map";
        coverage = "on";

            
            
        reg reg1 { 
           hdl_path = "reggroup1_reg1";
           coverage = "on";
           regwidth = 32;
          field {
            hdl_path = "_fld_q";
            hw = rw;
            sw = rw;
            

          } fld[31:0] = 32'h0;

        };
 
            
        reg reg2 { 
           hdl_path = "reggroup1_reg2";
           coverage = "on";
           regwidth = 32;
          field {
            hdl_path = "_fld1_q";
            hw = rw;
            sw = rw;
            

          } fld1[31:0] = 32'h0;

        };
 
         
        reg1 reg1 @0x00;

        reg2 reg2 @0x04;

      };
      
      reg1 reg1 @0x00;

      ref_name_ref_name_reggroup1  ref_name_ref_name_reggroup1 @0x04 += 0x8;

    };
   
    reggroup1  reggroup1 @0x00 += 0x8;

    ref_name  ref_name @0x08 += 0xC;

  };
  block1  block1 @0x00 += 0xC;
        
  block2  block2 @0x0C += 0x14;
        
};    
