#Agnisys, Inc. ***** Copyright 2018 All Rights Reserved. *****
#
#*** This file is auto generated by IDesignSpec (http://www.agnisys.com) . Please do not edit this file. ***
# created by        : 
# generated by      : Admin
# generated from    : C:\Users\Admin\Documents\GitHub\git_test\Allegro_test\case1\case1.idsng
# IDesignSpec rev   : idsbatch v4.16.26.2

#*** This code is generated with following settings ***
# Reg Width                  : 32
# Address Unit               : 8
# C++ Types int              : hwint
# Bus Type                   : AXI
# BigEndian                  : false
# LittleEndian               : false
# Dist. Decode and Readback  : false
#--------------------------------------------------------------------------------------------------------------- 
# chip : chip_name

system  chip_name {
        bytes 4;
  
  block block1 (block1_idsinst) @'h0  {
    bytes 4;
    cover +a+b+f;
        register reg1 (reg1) @'h0 {
          bytes 4;
          cover +b+f;
          field fld (_fld_q) @0 {
            cover +b+f;
            access rw;
            reset  0x0;
            bits   32;
                   }
        }
     regfile reggroup1  @'h4 {
     cover +a+b+f;
        register reg1 (reggroup1_reg1) @'h0 {
          bytes 4;
          cover +b+f;
          field fld (_fld_q) @0 {
            cover +b+f;
            access rw;
            reset  0x0;
            bits   32;
                   }
        }
        register reg2 (reggroup1_reg2) @'h4 {
          bytes 4;
          cover +b+f;
          field fld1 (_fld1_q) @0 {
            cover +b+f;
            access rw;
            reset  0x0;
            bits   32;
                   }
        }
     }
                
  }

  block block2 (block2_idsinst) @'hC  {
    bytes 4;
    cover +a+b+f;
     regfile reggroup1  @'h0 {
     cover +a+b+f;
        register reg1 (reggroup1_reg1) @'h0 {
          bytes 4;
          cover +b+f;
          field fld (_fld_q) @0 {
            cover +b+f;
            access rw;
            reset  0x0;
            bits   32;
                   }
        }
        register reg2 (reggroup1_reg2) @'h4 {
          bytes 4;
          cover +b+f;
          field fld1 (_fld1_q) @0 {
            cover +b+f;
            access rw;
            reset  0x0;
            bits   32;
                   }
        }
     }
                
     regfile ref_name  @'h8 {
     cover +a+b+f;
        register reg1 (ref_name_reg1) @'h0 {
          bytes 4;
          cover +b+f;
          field fld (_fld_q) @0 {
            cover +b+f;
            access rw;
            reset  0x0;
            bits   32;
                   }
        }
     }
                
  }

}
