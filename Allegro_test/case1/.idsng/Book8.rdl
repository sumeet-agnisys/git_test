//Agnisys, Inc. ***** Copyright 2018 All Rights Reserved. *****
//
//*** This file is auto generated by IDesignSpec (http://www.agnisys.com) . Please do not edit this file. ***
// created by        : 
// generated by      : Admin
// generated from    : C:\Users\Admin\Documents\GitHub\git_test\Allegro_test\case1\Book8.idsng
// IDesignSpec rev   : idsbatch v4.16.26.2

//*** This code is generated with following settings ***
// Reg Width                  : 32
// Address Unit               : 8
// C++ Types int              : hwint
// Bus Type                   : AXI
// BigEndian                  : false
// LittleEndian               : false
// Dist. Decode and Readback  : false
//---------------------------------------------------------------------------------------------------------------     
// chip : chip1

addrmap chip1 {
  name = "chip1 Address Map";
    
  addrmap block1 {
    name = "block1 Address Map";

      
      
    addrmap reggroup1 {
      name = "reggroup1 Address Map";

         
         
      reg reg1 { 
         regwidth = 32;
        field {
          hw = rw;
          sw = rw;
          

        } f1[31:0] = 32'h0;

      };
 
      
      reg1 reg1 @0x0;

    };
   
    reggroup1  reggroup1 @0x0 += 0x4;

  };
  addrmap block2 {
    name = "block2 Address Map";

      
      
    reg reg2 { 
       regwidth = 32;
      field {
        hw = rw;
        sw = rw;
        

      } f1[31:0] = 32'h0;

    };
 
      
    addrmap block3 {
      name = "block3 Address Map";
      map_type = "subblock";

         
         
         
      addrmap block3_reggroup1 {
        name = "block3_reggroup1 Address Map";

            
            
        reg reg1 { 
           regwidth = 32;
          field {
            hw = rw;
            sw = rw;
            

          } f1[31:0] = 32'h0;

        };
 
         
        reg1 reg1 @0x0;

      };
      
      block3_reggroup1  block3_reggroup1 @0x0 += 0x4;

    };
   
    reg2 reg2 @0x0;

    block3  block3 @0x4 += 0x4;

  };
  block1  block1 @0x0 += 0x4;
        
  block2  block2 @0x4 += 0x8;
        
};    
