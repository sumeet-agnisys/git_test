#Agnisys, Inc. ***** Copyright 2018 All Rights Reserved. *****
#
#*** This file is auto generated by IDesignSpec (http://www.agnisys.com) . Please do not edit this file. ***
# created by        : 
# generated by      : Admin
# generated from    : C:\Users\Admin\Documents\GitHub\git_test\Allegro_test\case1\Book8.idsng
# IDesignSpec rev   : idsbatch v4.16.26.2

#*** This code is generated with following settings ***
# Reg Width                  : 32
# Address Unit               : 8
# C++ Types int              : hwint
# Bus Type                   : AXI
# BigEndian                  : false
# LittleEndian               : false
# Dist. Decode and Readback  : false
#--------------------------------------------------------------------------------------------------------------- 
# chip : chip1

system  chip1 {
        bytes 4;
  
  block block1  @'h0  {
    bytes 4;
    
        register reggroup1  @'h0 {
          bytes 4;
          
          field f1  @0 {
            
            access rw;
            reset  0x0;
            bits   32;
                   }
        }
  }

  block block2  @'h4  {
    bytes 4;
    
        register reg2  @'h0 {
          bytes 4;
          
          field f1  @0 {
            
            access rw;
            reset  0x0;
            bits   32;
                   }
        }
     regfile block3  @'h4 {
     
        register block3_reggroup1  @'h0 {
          bytes 4;
          
          field f1  @0 {
            
            access rw;
            reset  0x0;
            bits   32;
                   }
        }
     }
                
  }

}
