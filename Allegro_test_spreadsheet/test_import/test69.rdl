//Agnisys, Inc. ***** Copyright 2018 All Rights Reserved. *****
//
//*** This file is auto generated by IDesignSpec (http://www.agnisys.com) . Please do not edit this file. ***
// created by        : 
// generated by      : Saurabh
// generated from    : C:\Users\Anupam\Documents\GitHub\git_test\Allegro_test\test_import\test69.idsng
// IDesignSpec rev   : idsbatch v4.16.26.2

//*** This code is generated with following settings ***
// Reg Width                  : 8
// Address Unit               : 8
// C++ Types int              : hwint
// Bus Type                   : PROPRIETARY
// BigEndian                  : false
// LittleEndian               : false
// Dist. Decode and Readback  : false
//--------------------------------------------------------------------------------------------------------------- 
addrmap test69 {
  name = "test69 Address Map";
   
   
  reg regname { 
     regwidth = 8;
    field {
      hw = r;
      sw = rw;
      
    } ff[1:1] = 1'h0;
  };
 
   
  reg regname2 { 
     regwidth = 8;
    field {
      hw = r;
      sw = rw;
      
    } fx[7:0] = 8'h0;
  };
 
   
  regname regname @0x0000;
  regname2 regname2 @0x0001;
};
