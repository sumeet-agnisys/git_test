//Agnisys, Inc. ***** Copyright 2018 All Rights Reserved. *****
//
//*** This file is auto generated by IDesignSpec (http://www.agnisys.com) . Please do not edit this file. ***
// created by        : 
// generated by      : Saurabh
// generated from    : C:\Users\Anupam\Documents\GitHub\git_test\Allegro_test\test_import\output\test68.idsng
// IDesignSpec rev   : idsbatch v4.16.26.2

//*** This code is generated with following settings ***
// Reg Width                  : 32
// Address Unit               : 8
// C++ Types int              : hwint
// Bus Type                   : PROPRIETARY
// BigEndian                  : false
// LittleEndian               : false
// Dist. Decode and Readback  : false
//---------------------------------------------------------------------------------------------------------------     
// chip : chipname
//TOP:chip:chipname

addrmap chipname {
  name = "chipname Address Map";
    
  addrmap test68 {
    name = "test68 Address Map";
      
      
    reg regname { 
       regwidth = 32;
      field {
        hw = r;
        sw = rw;
        
      } f1[31:10] = 22'h0;
      field {
        hw = r;
        sw = rw;
        
      } f2[4:0] = 5'h0;
    };
 
      
    reg regname2 { 
       regwidth = 8;
      field {
        hw = r;
        sw = rw;
        
      } fx122[5:4] = 2'h0;
    };
 
   
    regname regname @0x0000;
    regname2 regname2 @0x0004;
  };
  test68  test68 @0x0000 += 0x5;
        
};    
