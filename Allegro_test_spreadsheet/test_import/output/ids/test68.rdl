// 
//
//*** This file is auto generated by IDesignSpec (http://www.agnisys.com) . Please do not edit this file. ***
// created by        : 
// generated by      : Saurabh
// generated from    : C:\Users\Anupam\Documents\GitHub\git_test\Allegro_test\test_import\output\test68.idsng
// IDesignSpec rev   : idsbatch v 6.16.2.110 

//*** This code is generated with following settings ***
// Reg Width                  : 32
// Address Unit               : 8
// C++ Types int              : hwint
// Bus Type                   : AMBA-AHB
// BigEndian                  : true
// LittleEndian               : true
// Dist. Decode and Readback  : false
//---------------------------------------------------------------------------------------------------------------     
// chip : chipname

addrmap chipname {
  name = "chipname Address Map";
    
  addrmap test68 {
    name = "test68 Address Map";

      
      
    reg regname { 
       regwidth = 32;
      field {
        hw = r;
        sw = rw;
        
      } f1[31:0] = 32'h0;

    };
 
   
    regname regname @0x0;

  };
  test68  test68 @0x0 += 0x4;
        
};    
